* This file is intentionally identical to diamond-mine-shimmer.cir.
* Some simulators prefer the .sp extension.
.include "diamond-mine-shimmer.cir"
