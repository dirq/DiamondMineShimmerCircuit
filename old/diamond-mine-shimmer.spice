* This file is intentionally identical in behavior to diamond-mine-shimmer.cir.
* Some simulators prefer the .spice extension.
.include "diamond-mine-shimmer.cir"
